ADE simulation setup
Test FinalProject_ALU_Playground_1: FinalProject/ALU_Playground/schematic, simulator spectre
  Models: /data/cadence/gpdk/CDK045/gpdk045_v_6_0/gpdk045/../models/spectre/gpdk045.scs[mc]
  Variables: T = 4u
  Temperature: 27
  Analysis tran: stop=15*VAR("T")
  Output QOP = awvCreateBus("QOP" list(awvAnalog2Digital(VT("/QOP<4>") nil nil 0.7 nil "centre") awvAnalog2Digital(VT("/QOP<3>") nil nil 0.7 nil "centre") awvAnalog2Digital(VT("/QOP<2>") nil nil 0.7 nil "centre") awvAnalog2Digital(VT("/QOP<1>") nil nil 0.7 nil "centre") awvAnalog2Digital(VT("/QOP<0>") nil nil 0.7 nil "centre")) "Binary")
  Output A = awvCreateBus("A" list(awvAnalog2Digital(VT("/A3") nil nil 0.7 nil "centre") awvAnalog2Digital(VT("/A2") nil nil 0.7 nil "centre") awvAnalog2Digital(VT("/A1") nil nil 0.7 nil "centre") awvAnalog2Digital(VT("/A0") nil nil 0.7 nil "centre")) "Binary")
  Output B = awvCreateBus("B" list(awvAnalog2Digital(VT("/B3") nil nil 0.7 nil "centre") awvAnalog2Digital(VT("/B2") nil nil 0.7 nil "centre") awvAnalog2Digital(VT("/B1") nil nil 0.7 nil "centre") awvAnalog2Digital(VT("/B0") nil nil 0.7 nil "centre")) "Binary")
  Output RegA = awvCreateBus("RegA" list(awvAnalog2Digital(VT("/RegA<4>") nil nil 0.7 nil "centre") awvAnalog2Digital(VT("/RegA<3>") nil nil 0.7 nil "centre") awvAnalog2Digital(VT("/RegA<2>") nil nil 0.7 nil "centre") awvAnalog2Digital(VT("/RegA<1>") nil nil 0.7 nil "centre")) "Binary")
  Output Y = awvCreateBus("Y" list(awvAnalog2Digital(VT("/Y<4>") nil nil 0.7 nil "centre") awvAnalog2Digital(VT("/Y<3>") nil nil 0.7 nil "centre") awvAnalog2Digital(VT("/Y<2>") nil nil 0.7 nil "centre") awvAnalog2Digital(VT("/Y<1>") nil nil 0.7 nil "centre")) "Binary")
  Signals: /A3, /A2, /A1, /A0, /B3, /B2, /B1, /B0, /OP4, /OP3, /OP2, /OP1, /OP0, /Y<4>, /Y<3>, /Y<2>, /Y<1>, /RegA<4>, /RegA<3>, /RegA<2>, /RegA<1>, /QOP<4>, /QOP<3>, /QOP<2>, /QOP<1>, /QOP<0>, /CLK
Run mode: Single Run, Sweeps and Corners
