ADE simulation setup
Run mode: Single Run, Sweeps and Corners
Tests:
  FinalProject_ALU_Playground_1: FinalProject/ALU_Playground/schematic, simulator spectre
    Variables: T = 4u
