ADE simulation setup
Test FinalProject_playground_1_LAYOUT_1: FinalProject/playground/schematic, simulator spectre
  Models: /data/cadence/gpdk/CDK045/gpdk045_v_6_0/gpdk045/../models/spectre/gpdk045.scs[mc]
  Variables: T = 0.1u
  Temperature: 27
  Analysis tran: stop=16*VAR("T")
  Signals: /A, /C, /B, /D, /Vblack_P, /Vblack_G, /Vcount<1>, /Vcount<2>, /Vcount<3>, /Vcount<4>, /SUB, /YXOR<4>, /YXOR<3>, /YXOR<2>, /YXOR<1>, /Vout
