ADE simulation setup
Test FinalProject_playground_FinalTestLayout: FinalProject/playground/schematic, simulator spectre
  Models: /data/cadence/gpdk/CDK045/gpdk045_v_6_0/gpdk045/../models/spectre/gpdk045.scs[mc]
  Variables: T = 0.1u
  Temperature: 27
  Analysis tran: stop=8*VAR("T")
  Signals: /A0, /A1, /A2, /A3, /QA<0>, /QA<1>, /QA<2>, /QA<3>, /B0, /B1, /B2, /B3, /QB<0>, /QB<1>, /QB<2>, /QB<3>, /OP4, /OP3, /OP2, /OP1, /OP0, /QOP<0>, /QOP<1>, /QOP<2>, /QOP<3>, /QOP<4>, /CLK, /Y0, /Y1, /Y2, /Y3, /Q0, /Q1, /Q2, /Q3, /S<4>, /S<3>, /S<2>, /S<1>, /TestY, /TestD
