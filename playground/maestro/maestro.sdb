ADE simulation setup
Run mode: Single Run, Sweeps and Corners
Tests:
  FinalProject_playground_1: FinalProject/playground/schematic, simulator spectre
    Variables: T = 0.1u
  FinalProject_playground_1_LAYOUT: FinalProject/playground/schematic, simulator spectre
    Variables: T = 0.1u
  FinalProject_playground_FinalTestLayout: FinalProject/playground/schematic, simulator spectre
    Variables: T = 0.1u
    Outputs: "/\\\\"
