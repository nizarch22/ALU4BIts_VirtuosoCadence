ADE simulation setup
Test FinalProject_AdderSub_test_1: FinalProject/AdderSub_test/schematic, simulator spectre
  Models: /data/cadence/gpdk/CDK045/gpdk045_v_6_0/gpdk045/../models/spectre/gpdk045.scs[mc]
  Variables: T = 1u; VDD = 1.2
  Temperature: 27
  Analysis tran: stop=512*VAR("T")
  Signals: /A<4:1>, /B<4:1>, /S<4:1>, /Cin, /I1/Cin (terminal), /A11, /A22, /A33, /A44, /V2/MINUS (terminal), /V2/PLUS (terminal)
Run mode: Single Run, Sweeps and Corners
