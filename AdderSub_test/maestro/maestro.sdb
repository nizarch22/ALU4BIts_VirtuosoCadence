ADE simulation setup
Run mode: Single Run, Sweeps and Corners
Tests:
  FinalProject_AdderSub_test_1: FinalProject/AdderSub_test/schematic, simulator spectre
    Variables: T = 1u; VDD = 1.2
